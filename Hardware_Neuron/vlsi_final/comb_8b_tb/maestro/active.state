ADE simulation setup
Test final_stuff_comb_8b_tb_1: vlsi_final/comb_8b_tb/config, simulator spectre
  Models: /opt/cadence-designkits/gpdk045_v_6_0/gpdk045/../models/spectre/gpdk045.scs[mc]
  Variables: A = 1; reset = 1; tf = 1f; tr = 1f; vdd = 1; T = 2n; B = 1
  Temperature: 27
  Analysis tran: stop=256n errpreset=conservative
  Signals: /b<3:0>, /a<3:0>, /out<7:0>
Run mode: Single Run, Sweeps and Corners
