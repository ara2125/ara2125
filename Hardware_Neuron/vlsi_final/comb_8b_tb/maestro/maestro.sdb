ADE simulation setup
Run mode: Single Run, Sweeps and Corners
Tests:
  final_stuff_comb_8b_tb_1: vlsi_final/comb_8b_tb/config, simulator spectre
    Variables: T = 2n; A = 1; reset = 1; tf = 1f; tr = 1f; vdd = 1; B = 1
