ADE simulation setup
Run mode: Single Run, Sweeps and Corners
Tests:
  vlsi_final_neural_network_1: vlsi_final/neural_network/schematic, simulator spectre
    Variables: vdd = 1; reset = 1; A = 0; B = 0; T = 1n; s = 1; tf = 1f; tr = 1f
