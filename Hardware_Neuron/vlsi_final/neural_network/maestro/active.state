ADE simulation setup
Test vlsi_final_neural_network_1: vlsi_final/neural_network/schematic, simulator spectre
  Models: /opt/cadence-designkits/gpdk045_v_6_0/gpdk045/../models/spectre/gpdk045.scs[mc]
  Variables: vdd = 1; reset = 1; A = 0; B = 0; T = 1n; s = 1; tf = 1f; tr = 1f
  Temperature: 27
  Analysis tran: stop=20n errpreset=conservative
  Signals: /out<3:0>, /w_init<3:0>, /w00<3:0>, /w01<3:0>, /w10<3:0>, /w11<3:0>, /w20<3:0>, /w21<3:0>, /clk_a, /clk_b, /preset, /x0<3:0>, /x1<3:0>, /out00<3:0>, /out01<3:0>, /out10<3:0>, /out11<3:0>
Run mode: Single Run, Sweeps and Corners
