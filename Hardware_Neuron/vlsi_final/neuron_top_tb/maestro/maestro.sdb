ADE simulation setup
Run mode: Single Run, Sweeps and Corners
Tests:
  final_project_neuron_top_tb_1: final_project/neuron_top_tb/schematic, simulator spectre
    Variables: A = 1; reset = 1; T = 400p; tf = 0.1p; tr = 0.1p; vdd = 1; aw0 = 0; aw1 = 1; aw2 = 0; aw3 = 0; ax0 = 0; ax1 = 0; ax2 = 1; ax3 = 0; bw0 = 0; bw1 = 1; bw2 = 0; bw3 = 0; bx0 = 0; bx1 = 0; bx2 = 0; bx3 = 0
