ADE simulation setup
Test final_project_neuron_top_tb_1: final_project/neuron_top_tb/schematic, simulator spectre
  Models: /opt/cadence-designkits/gpdk045_v_6_0/gpdk045/../models/spectre/gpdk045.scs[mc]
  Variables: bw0 = 0; bw1 = 1; bw2 = 0; bw3 = 0; bx0 = 0; bx1 = 0; bx2 = 0; bx3 = 0; aw0 = 0; aw1 = 1; aw2 = 0; aw3 = 0; ax0 = 0; ax1 = 0; ax2 = 1; ax3 = 0; A = 1; reset = 1; T = 400p; tf = 0.1p; tr = 0.1p; vdd = 1
  Temperature: 27
  Analysis tran: stop=100n
  Signals: /x0<3>, /x0<2>, /x0<1>, /x0<0>, /w0<3>, /w0<2>, /w0<1>, /w0<0>, /preset, /out<3:0>, /clk_a, /clk_b, /I0/a<0>, /I0/a<1>, /I0/a<2>, /I0/a<3>, /I0/a<4>, /I0/net7<0:4>
Run mode: Single Run, Sweeps and Corners
