ADE simulation setup
Test final_project_relu_TB_1: final_project/relu_TB/schematic, simulator spectre
  Models: /opt/cadence-designkits/gpdk045_v_6_0/gpdk045/../models/spectre/gpdk045.scs[mc]
  Variables: A = 1; reset = 1; T = 1n; tf = 10p; tr = 10p; vdd = 1
  Temperature: 27
  Analysis tran: stop=64n errpreset=conservative
  Signals: /in<0>, /in<1>, /in<2>, /in<3>, /in<4>, /out<0>, /out<1>, /out<2>, /out<3>
Run mode: Single Run, Sweeps and Corners
