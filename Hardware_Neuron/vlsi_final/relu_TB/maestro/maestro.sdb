ADE simulation setup
Run mode: Single Run, Sweeps and Corners
Tests:
  final_project_relu_TB_1: final_project/relu_TB/schematic, simulator spectre
    Variables: A = 1; reset = 1; T = 1n; tf = 10p; tr = 10p; vdd = 1
