ADE simulation setup
Run mode: Single Run, Sweeps and Corners
Tests:
  final_project_ring_counter_TB_1: final_project/ring_counter_TB/schematic, simulator spectre
    Variables: A = 1; T = 0.5n; tf = 1p; tr = 1p; vdd = 1
