ADE simulation setup
Test final_project_ring_counter_TB_1: final_project/ring_counter_TB/schematic, simulator spectre
  Models: /opt/cadence-designkits/gpdk045_v_6_0/gpdk045/../models/spectre/gpdk045.scs[mc]
  Variables: A = 1; T = 0.5n; tf = 1p; tr = 1p; vdd = 1
  Temperature: 27
  Analysis tran: stop=20n
  Signals: /out<2>, /out<1>, /out<0>, /clk, /inv_r, /r
Run mode: Single Run, Sweeps and Corners
